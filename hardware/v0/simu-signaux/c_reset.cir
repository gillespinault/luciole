Luciole2 v0 - C mise sous tension et reset : EN, U5, SW1, GPIO8, GPIO9
* Lancer depuis hardware/ :  tools/kicad ngspice -b v0/simu-signaux/c_reset.cir
*
* Intention du schéma (circuit.py) : R18 de 100 kΩ et C10 de 100 nF, « même
* constante de temps que les 10 kΩ et 1 µF d'Espressif, mais dix fois moins de
* courant quand le superviseur tient EN à la masse, batterie vide ». U5
* (TLV803EA30, drain ouvert) tient EN à 0 tant que le 3,3 V est sous son seuil,
* puis encore 200 ms. R19 et R20 de 10 kΩ tiennent GPIO9 et GPIO8 à 1.
*
* Exigence d'Espressif (fiche de la puce v1.6, figure 2-4 et tableau 2-15) : EN
* doit rester sous 0,25 × VDD (0,825 V) au moins 50 µs après que l'alimentation a
* atteint 2,8 V ; le reset se relâche quand EN passe 0,75 × VDD (2,475 V). Au
* relâchement, GPIO9 à 1 lance le programme (GPIO8 indifférent) ; tableau 3-3.
*
* Ce qu'on lit : la marge entre « 3,3 V à 2,8 V » et « EN repasse 0,825 V » (il
* faut plus de 50 µs), la durée totale du reset, le plus haut niveau de EN avant
* que U5 ne le tienne (sa sortie n'est pas définie sous 0,7 V), les niveaux de
* GPIO8 et GPIO9 quand EN passe 2,475 V. Puis : sans U5, appui sur SW1, creux du 3,3 V.

.include modeles/modeles.lib

* tmont : durée de montée du 3,3 V, à partir de 1 ms
.param tmont=1m
* avecu5 : 1 = U5 monté ; 0 = retiré (pour voir ce qu'il apporte)
.param avecu5=1
.param td5=0.2
.param c10={100n}
.param r18=100k
* essai : 0 mise sous tension seule ; 1 appui sur SW1 de 20 ms à 0,6 s ;
*         2 creux du 3,3 V à 3,0 V pendant 2 ms à 0,6 s
.param essai=0
.param vcreux={essai == 2 ? 3.0 : 3.3}

V33   v33 0 pwl(0 0 1m 0 {1m + tmont} 3.3 600m 3.3 600.1m {vcreux} 602m {vcreux} 602.1m 3.3)
R18   v33 en {r18}
C10   en 0 {c10}
XU5   v33 en5 0 TLV803 td={td5}
R5x   en5 en {avecu5 == 1 ? 1m : 1e12}
* SW1 : 0,5 Ω fermé
Vsw   swc 0 pwl(0 0 600m 0 600.01m {essai == 1 ? 1 : 0} 620m {essai == 1 ? 1 : 0} 620.01m 0)
S1    en 0 swc 0 SWB
.model SWB sw(vt=0.5 vh=0.1 ron=0.5 roff=1e12)
* entrée EN du module (hypothèse : 5 pF, pas de rappel)
Cen   en 0 5p
* GPIO9 (BOOT) : R19, SW2 ouvert, rappel interne de 45 kΩ au reset
R19   v33 boot 10k
Vz    zero 0 0
XIO9  boot v33 0 zero zero ESPPIN rpu=45k
* GPIO8 (STRAP8) : R20, broche en l'air au reset
R20   v33 strap8 10k
XIO8  strap8 v33 0 zero zero ESPPIN

.control
set noaskquit
echo "RESULTAT C mise sous tension ; montee du 3,3 V (s) ; U5 (1 monte, 0 retire) ; delai de U5 (s) ; C10 (F) ; instant 3,3 V = 2,8 V (s) ; marge jusqu'a EN = 0,825 V (s, il faut > 50e-6) ; duree du reset, de 2,8 V a EN = 2,475 V (s) ; EN le plus haut avant le maintien par U5 (V) ; a EN = 2,475 V : 3,3 V (V) ; GPIO8 (V) ; GPIO9 (V)"
foreach u 1 0
  foreach m 1m 50m
    foreach d 0.13 0.2 0.27
      foreach c 100n 10n
        alterparam avecu5 = $u
        alterparam tmont = $m
        alterparam td5 = $d
        alterparam c10 = $c
        alterparam essai = 0
        reset
        tran 20u 550m
        meas tran t28 when v(v33)=2.8 rise=1
        let tvil = -1
        let tvih = -1
        meas tran tvil when v(en)=0.825 rise=last
        meas tran tvih when v(en)=2.475 rise=last
        let tfin = t28
        if $u = 1
          let tfin = t28 + 0.05
        end
        meas tran enmax max v(en) from=0 to=$&tfin
        meas tran v33r find v(v33) at=$&tvih
        meas tran g8 find v(strap8) at=$&tvih
        meas tran g9 find v(boot) at=$&tvih
        let marge = tvil - t28
        let duree = tvih - t28
        echo "RESULTAT C mise sous tension ; $m ; $u ; $d ; $c ; $&t28 ; $&marge ; $&duree ; $&enmax ; $&v33r ; $&g8 ; $&g9"
        destroy all
      end
    end
  end
end
alterparam avecu5 = 1
alterparam tmont = 1m
alterparam td5 = 0.2
alterparam c10 = 100n

echo "RESULTAT C appui sur SW1 (20 ms a partir de 0,6 s) ; EN pendant l'appui (V) ; temps passe sous 0,825 V apres le relachement (s, il faut > 50e-6) ; delai de retour a 2,475 V apres le relachement (s)"
alterparam essai = 1
reset
tran 20u 800m
meas tran enbas find v(en) at=610m
meas tran t1 when v(en)=0.825 td=620m rise=1
meas tran t2 when v(en)=2.475 td=620m rise=1
let d1 = t1 - 620m
let d2 = t2 - 620m
echo "RESULTAT C appui sur SW1 ; $&enbas ; $&d1 ; $&d2"
destroy all

echo "RESULTAT C creux du 3,3 V a 3,0 V pendant 2 ms (a 0,6 s) : U5 doit relancer un reset ; EN le plus bas (V) ; duree sous 0,825 V (s) ; retour a 2,475 V apres le debut du creux (s)"
alterparam essai = 2
reset
tran 20u 1
meas tran enmin min v(en) from=600m to=1
let ta = -1
let tb = -1
let tc = -1
meas tran ta when v(en)=0.825 td=600m fall=1
meas tran tb when v(en)=0.825 td=600m rise=1
meas tran tc when v(en)=2.475 td=600m rise=1
let d1 = tb - ta
let d2 = tc - 600m
echo "RESULTAT C creux du 3,3 V ; $&enmin ; $&d1 ; $&d2"
quit
.endc
.end
